** sch_path: /foss/designs/chipify/examples/source_follower/tb/tb_sf_op_vacask.sch
**.subckt tb_sf_op_vacask
E1 inp net1 VOL=' v(vdin)/2 '
E2 inn net1 VOL=' -v(vdin)/2 '
V1 net1 GND dc={{vincm}}
.save i(v1)
V2 vdd GND dc={{vdd}}
V5 net2 GND dc=0.35
.save i(v5)
V4 GND vdin dc=0
.save i(v4)
x1 vdd inn inp outp outn net2 GND source_follower
**** begin user architecture code

**** end user architecture code
**.ends

* expanding   symbol:  chipify/examples/source_follower/sch/source_follower.sym # of pins=7
** sym_path: /foss/designs/chipify/examples/source_follower/sch/source_follower.sym
** sch_path: /foss/designs/chipify/examples/source_follower/sch/source_follower.sch
.subckt source_follower vdd inn inp outp outn vbias vss
*.ipin vbias
*.iopin vdd
*.opin outp
*.iopin vss
*.opin outn
*.ipin inp
*.ipin inn
XM1 outp vbias vss vss sg13_lv_nmos w=100u l=2u ng=20 m=1 mm_ok=1
XM2 vdd inp outp vss sg13_lv_nmos w=200u l=0.13u ng=20 m=1 mm_ok=1
XM3 outn vbias vss vss sg13_lv_nmos w=100u l=2u ng=20 m=1 mm_ok=1
XM4 vdd inn outn vss sg13_lv_nmos w=200u l=0.13u ng=20 m=1 mm_ok=1
.ends

.GLOBAL GND
.end
